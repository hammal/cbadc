// This file was autogenerated using the
// cbadc toolbox, see https://github.com/hammal/cbadc
// and is thereby valid under the
//
// GNU General Public License v3.0
// (see https://github.com/hammal/cbadc/blob/master/LICENCE)
//
// This file was generated at
//
// 2022-11-11T16:55:54.194171
//
// using the cbadc package version
//
// 0.2.2
//
`include "constants.vams"
`include "disciplines.vams"

// comparator
//
// Ports: vdd, vgd, vsgd, clk, s_tilde, s
//
// Parameters: dly, ttime
//
// Functional Description:
//
// A comparator implementation where
// the output signal s(t) is updated at the
// falling edge of the V(clk) signal depending
// on the input signal V(s_tilde) is above or
// below a given threshold.
//
// threshold determines the descision threshold.
// Furthermore, dly and ttime specifies how quickly the
// comparator can switch its output.
//
module comparator(vdd, vgd, vsgd, clk, s_tilde, s);

    input vdd; // positive supply
    input vgd; // ground
    input vsgd; // signal ground
    input clk; // clock signal
    input s_tilde;
    output s;

    parameter real dly = 0.0;
    parameter real ttime = 10p;

    electrical vdd; // positive supply
    electrical vgd; // ground
    electrical vsgd; // signal ground
    electrical clk; // clock signal
    electrical s_tilde;
    electrical s;

    real vout; // Output voltage value

    analog begin
        @(cross(V(clk) - V(vsgd), -1)) begin
        	if(V(s_tilde) > V(vsgd)) begin
        		vout=V(vdd, vgd);
        	end
        	else begin
        		vout = V(vgd);
        	end
        end
        V(s, vgd) <+ vout * transition(1.0, dly, ttime);
    end

endmodule

// digital_control
//
// Ports: vdd, vgd, vsgd, clk, s_tilde_0, s_tilde_1, s_tilde_2, s_tilde_3, s_tilde_4, s_0, s_1, s_2, s_3, s_4
//
// Parameters:
//
// Functional Description:
//
// A digital control which mainly connects
// M comparators to the input and outputs of
// the module itself.
//
module digital_control(vdd, vgd, vsgd, clk, s_tilde_0, s_tilde_1, s_tilde_2, s_tilde_3, s_tilde_4, s_0, s_1, s_2, s_3, s_4);

    input vdd; // positive supply
    input vgd; // ground
    input vsgd; // signal ground
    input clk; // clock signal
    input s_tilde_0;
    input s_tilde_1;
    input s_tilde_2;
    input s_tilde_3;
    input s_tilde_4;
    output s_0;
    output s_1;
    output s_2;
    output s_3;
    output s_4;

    electrical vdd; // positive supply
    electrical vgd; // ground
    electrical vsgd; // signal ground
    electrical clk; // clock signal
    electrical s_tilde_0;
    electrical s_tilde_1;
    electrical s_tilde_2;
    electrical s_tilde_3;
    electrical s_tilde_4;
    electrical s_0;
    electrical s_1;
    electrical s_2;
    electrical s_3;
    electrical s_4;

    comparator q_0 (
            .vdd(vdd),
            .vgd(vgd),
            .vsgd(vsgd),
            .clk(clk),
            .s_tilde(s_tilde_0),
            .s(s_0)
    );

    comparator q_1 (
            .vdd(vdd),
            .vgd(vgd),
            .vsgd(vsgd),
            .clk(clk),
            .s_tilde(s_tilde_1),
            .s(s_1)
    );

    comparator q_2 (
            .vdd(vdd),
            .vgd(vgd),
            .vsgd(vsgd),
            .clk(clk),
            .s_tilde(s_tilde_2),
            .s(s_2)
    );

    comparator q_3 (
            .vdd(vdd),
            .vgd(vgd),
            .vsgd(vsgd),
            .clk(clk),
            .s_tilde(s_tilde_3),
            .s(s_3)
    );

    comparator q_4 (
            .vdd(vdd),
            .vgd(vgd),
            .vsgd(vsgd),
            .clk(clk),
            .s_tilde(s_tilde_4),
            .s(s_4)
    );

endmodule
