// This file was autogenerated using the
// cbadc toolbox, see https://github.com/hammal/cbadc
// and is thereby valid under the
//
// GNU General Public License v3.0
// (see https://github.com/hammal/cbadc/blob/master/LICENCE)
//
// This file was generated at
//
// 2022-05-17T16:16:49.851054
//
// using the cbadc package version
//
// 0.2.1
//
`include "constants.vams"
`include "disciplines.vams"

// analog_system
//
// Ports: vdd, vgd, vsgd, u_0, s_0, s_1, s_2, s_3, s_tilde_0, s_tilde_1, s_tilde_2, s_tilde_3
//
// Parameters:
//
// Functional Description
//
// The analog system directly modeled using differential
// equations.
//
// Specifically, we use the state space model equations
//
// ddt(x(t)) = A x(t) + B u(t) + Gamma s(t)
// s_tilde(t) = Gamma_tildeT x(t)
//
// where
//
// x(t) = [x_0, x_1, x_2, x_3]^T
// u(t) = [u_0]^T
// s(t) = [s_0, s_1, s_2, s_3]^T
// s_tilde(t) = [s_tilde_0, s_tilde_1, s_tilde_2, s_tilde_3]^T
//
// A ≈
// [0.00e+00, 3.46e+05, 0.00e+00, 0.00e+00]
// [-2.85e+07, 0.00e+00, 3.46e+05, 0.00e+00]
// [0.00e+00, -2.85e+07, 0.00e+00, 3.46e+05]
// [0.00e+00, 0.00e+00, -2.85e+07, 0.00e+00]
//
// B ≈
// [-2.85e+07]
// [0.00e+00]
// [0.00e+00]
// [0.00e+00]
//
// Gamma ≈
// [-2.85e+07, -0.00e+00, -0.00e+00, -0.00e+00]
// [-0.00e+00, -2.85e+07, -0.00e+00, -0.00e+00]
// [-0.00e+00, -0.00e+00, -2.85e+07, -0.00e+00]
// [-0.00e+00, -0.00e+00, -0.00e+00, -2.85e+07]
//
// Gamma_tildeT ≈
// [1.00e+00, 0.00e+00, 0.00e+00, 0.00e+00]
// [0.00e+00, 1.00e+00, 0.00e+00, 0.00e+00]
// [0.00e+00, 0.00e+00, 1.00e+00, 0.00e+00]
// [0.00e+00, 0.00e+00, 0.00e+00, 1.00e+00]
//
module analog_system(vdd, vgd, vsgd, u_0, s_0, s_1, s_2, s_3, s_tilde_0, s_tilde_1, s_tilde_2, s_tilde_3);

    input vdd; // positive supply
    input vgd; // ground
    input vsgd; // signal ground
    input u_0;
    input s_0;
    input s_1;
    input s_2;
    input s_3;

    output s_tilde_0;
    output s_tilde_1;
    output s_tilde_2;
    output s_tilde_3;

    analog begin
        ddt(V(x_0), sgd) <+ 346127.61798020673*V(x_1, sgd) -28514351.032380633*V(s_0, sgd) -28514351.032380633*V(u_0, sgd);
        ddt(V(x_1), sgd) <+ -28514351.032380633*V(x_0, sgd) 346127.61798020673*V(x_2, sgd) -28514351.032380633*V(s_1, sgd);
        ddt(V(x_2), sgd) <+ -28514351.032380633*V(x_1, sgd) 346127.61798020673*V(x_3, sgd) -28514351.032380633*V(s_2, sgd);
        ddt(V(x_3), sgd) <+ -28514351.032380633*V(x_2, sgd) -28514351.032380633*V(s_3, sgd);
        V(s_tilde_0, sgd) <+ 1.0*V(x_0, sgd);
        V(s_tilde_1, sgd) <+ 1.0*V(x_1, sgd);
        V(s_tilde_2, sgd) <+ 1.0*V(x_2, sgd);
        V(s_tilde_3, sgd) <+ 1.0*V(x_3, sgd);
    end

endmodule
