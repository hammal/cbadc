// This file was autogenerated using the
// cbadc toolbox, see https://github.com/hammal/cbadc
// and is thereby valid under the
//
// GNU General Public License v3.0
// (see https://github.com/hammal/cbadc/blob/master/LICENCE)
//
// This file was generated at
//
// 2022-11-11T16:55:54.199220
//
// using the cbadc package version
//
// 0.2.2
//
`include "constants.vams"
`include "disciplines.vams"

// observer
//
// Ports: vdd, vgd, vsgd, clk, in_0, in_1, out_0, out_1, io_0, io_1, io_2
//
// Parameters:
//
// Functional Description:
//
// A observer module for capturing signals to file.
//
module observer(vdd, vgd, vsgd, clk, in_0, in_1, out_0, out_1, io_0, io_1, io_2);

    input vdd; // positive supply
    input vgd; // ground
    input vsgd; // signal ground
    input clk; // clock signal
    input in_0;
    input in_1;
    input out_0;
    input out_1;
    input io_0;
    input io_1;
    input io_2;

    electrical vdd; // positive supply
    electrical vgd; // ground
    electrical vsgd; // signal ground
    electrical clk; // clock signal
    electrical in_0;
    electrical in_1;
    electrical out_0;
    electrical out_1;
    electrical io_0;
    electrical io_1;
    electrical io_2;
    integer fp; // For observer

    analog begin
        @(initial_step) begin
        	fp=$fopen("observations.csv","w");
        	$fwrite(fp,"in_0,in_1,out_0,out_1,io_0,io_1,io_2\n");
        end

        @(final_step) begin
        	$fclose(fp);
        end

        @(cross(V(clk) - V(vsgd), 1)) begin
        	$fstrobe(fp, "%f,%f,%f,%f,%f,%f,%f", V(in_0), V(in_1), V(out_0), V(out_1), V(io_0), V(io_1), V(io_2));
        end
    end

endmodule
