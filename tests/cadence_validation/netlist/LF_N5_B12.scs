// This file was autogenerated using the
// cbadc toolbox, see https://github.com/hammal/cbadc
// and is thereby valid under the
//
// GNU General Public License v3.0
// (see https://github.com/hammal/cbadc/blob/master/LICENCE)
//
// This file was generated at
//
// 2022-11-11T16:55:33.444394
//
// using the cbadc package version
//
// 0.2.2
//

simulator lang=spectre
global 0

ahdl_include "/Users/hammal/Projects/cbadc/tests/cadence_validation/netlist/analog_frontend.vams"

* Power Supply
VGND vgd 0 vsource dc=0.0 type=dc
VDD vdd 0 vsource dc=1.0 type=dc
VSG vsgd 0 vsource dc= 0.5 type=dc

* Clock
VCLK clk vgd vsource type=pulse val0=0.0 val1=1.0 period=4.7223545074247563e-08 rise=1e-14 fall=1e-14

* Input Signal
VS0 u_0 vgd vsource type=sine sinedc=0.0 ampl=1.0 freq=661746.1681639309 sinephase=0.0

* Analog frontend
analog_frontend vdd vgd vsgd clk u_0 s_0 s_1 s_2 s_3 s_4 analog_frontend

// Example analysis commands
//
// stop=(1 << 14) * clock_period
// strobefreq = 1 / clock_period
// strobedelay = clock_period / 4
//
tran tran cmin=0 stop=0.00019347486416919227 strobefreq=21175877.38124579 strobedelay=1.1805886268561891e-08 skipdc=yes

// Save analog frontend outputs
//save vdd vgd vsgd clk u_0 s_0 s_1 s_2 s_3 s_4 x_0 x_1 x_2 x_3 x_4 vdd vgd vsgd u_0 s_0 s_1 s_2 s_3 s_4 s_tilde_0 s_tilde_1 s_tilde_2 s_tilde_3 s_tilde_4
save *
