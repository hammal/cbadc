{% if comment %}{% for row in comment %}
{{ '//' }} {{ row }}
{% endfor %}
//
{% endif %}
module {{ module_name }}({% for p in ports %}{{ p.name }}{% if loop.last %}{% else %}, {% endif %}{% endfor %});
{% if inputs %}
{% for val in inputs %}

    input {{ val.name }};{% if val.comment %} {{ '//' }} {{ val.comment }}{% endif %}
{% endfor %}{% endif %}
{% if outputs %}
{% for val in outputs %}

    output {{ val.name }};{% if val.comment %} {{ '//' }} {{ val.comment }}{% endif %}
{% endfor %}{% endif %}
{% if inouts %}
{% for val in inouts %}

    inout {{ val.name }};{% if val.comment %} {{ '//' }} {{ val.comment }}{% endif %}
{% endfor %}{% endif %}
{% if real_parameters %}

    {% for val in real_parameters %}

    parameter real {{ val.name }}{% if val.initial_value is not none %} = {{ val.initial_value }}{% endif %};{% if val.comment %} {{ '//' }} {{ val.comment }}{% endif %}
{% endfor %}{% endif %}
{% if int_parameters %}
    {% for val in int_parameters %}

    parameter integer {{ val.name }}{% if val.initial_value is not none %} = {{ val.initial_value }}{% endif %};{% if val.comment %} {{ '//' }} {{ val.comment }}{% endif %}
{% endfor %}{% endif %}
{% if electricals %}
    {% for val in electricals %}

    electrical {{ val.name }};{% if val.comment %} {{ '//' }} {{ val.comment }}{% endif %}
{% endfor %}

{% endif %}
{% if real_variables %}

    {% for val in real_variables %}

    real {{ val.name }}{% if val.initial_value is not none %} = {{ val.initial_value }}{% endif %};{% if val.comment %} {{ '//' }} {{ val.comment }}{% endif %}
{% endfor %}{% endif %}
{% if int_variables %}
    {% for val in int_variables %}

    integer {{ val.name }}{% if val.initial_value is not none %} = {{ val.initial_value }}{% endif %};{% if val.comment %} {{ '//' }} {{ val.comment }}{% endif %}
{% endfor %}{% endif %}

{% if submodules %}

    {% for mod in submodules %}

    {{ mod.module.module_name }} {% if mod.parameters %}#(
        {% for p_map in mod.parameters %}
            .{{ p_map.name }}({{ p_map.name }}){% if loop.last %}{% else %}, {% endif %}

        {% endfor %}
    ) {% endif %}
{{ mod.module.instance_name }} (
            {% for index in range(mod.number_of_connections) %}
            .{{ mod.module.ports[index].name }}({{ mod.connections[index].name }}){% if loop.last %}{% else %},{% endif %}

    {% endfor %}
    );
{% endfor %}{% endif %}
{% if analog_initial %}

    analog initial begin
        {% for a in analog_initial %}
        {{ a }};
    {% endfor %}
    end
{% endif %}
{% if analog %}

    analog begin
        {% for a in analog %}
        {{ a }}
        {% endfor %}
    end
{% endif %}

endmodule
